; Independent but related PCells for the DiffAmpPcell_T28 split package.

procedure(DFT28_defineM4FramePCell(libName cellName)
  let((libId)
    libId = ddGetObj(libName)
    unless(libId error("DFT28_defineM4FramePCell: library %s not found" libName))
    pcDefinePCell(
      list(libId cellName "layout")
      ((Pw float 4.0) (Ps float 1.0) (Tr int 7) (Ra float 1.0) (M4Layer string "M4"))
      let((cv)
        cv = pcCellView
        DFT28_createM4Frame(cv Pw Ps Tr Ra M4Layer)
        printf("DFT28: created %s/%s M4 frame\n" libName cellName)
      )
    )
  )
)

procedure(DFT28_defineM4RingsPCell(libName cellName)
  let((libId)
    libId = ddGetObj(libName)
    unless(libId error("DFT28_defineM4RingsPCell: library %s not found" libName))
    pcDefinePCell(
      list(libId cellName "layout")
      ((Pw float 4.0) (Ps float 1.0) (Tr int 7) (Ra float 1.0) (M4Layer string "M4"))
      let((cv)
        cv = pcCellView
        DFT28_createM4Rings(cv Pw Ps Tr Ra M4Layer)
        printf("DFT28: created %s/%s M4 rings\n" libName cellName)
      )
    )
  )
)

procedure(DFT28_defineM3RingsPCell(libName cellName)
  let((libId)
    libId = ddGetObj(libName)
    unless(libId error("DFT28_defineM3RingsPCell: library %s not found" libName))
    pcDefinePCell(
      list(libId cellName "layout")
      ((Pw float 4.0) (Ps float 1.0) (Tr int 7) (Ra float 1.0) (M3Layer string "M3"))
      let((cv)
        cv = pcCellView
        DFT28_createM3Rings(cv Pw Ps Tr Ra M3Layer)
        printf("DFT28: created %s/%s M3 rings\n" libName cellName)
      )
    )
  )
)

procedure(DFT28_definePortBridgePCell(libName cellName)
  let((libId)
    libId = ddGetObj(libName)
    unless(libId error("DFT28_definePortBridgePCell: library %s not found" libName))
    pcDefinePCell(
      list(libId cellName "layout")
      ((Pw float 4.0) (Ps float 1.0) (Tr int 7) (Ra float 1.0)
       (M3Layer string "M3") (M4Layer string "M4") (M5Layer string "M5")
       (Via3 string "VIA3") (Via4 string "VIA4") (Via5 string "VIA5"))
      let((cv)
        cv = pcCellView
        DFT28_createPortBridge(cv Pw Ps Tr Ra M3Layer M4Layer M5Layer Via3 Via4 Via5)
        printf("DFT28: created %s/%s port bridge\n" libName cellName)
      )
    )
  )
)

procedure(DFT28_defineDemoTopPCell(libName cellName)
  let((libId)
    libId = ddGetObj(libName)
    unless(libId error("DFT28_defineDemoTopPCell: library %s not found" libName))
    pcDefinePCell(
      list(libId cellName "layout")
      ((Pw float 4.0) (Ps float 1.0) (Tr int 7) (Ra float 1.0)
       (M3Layer string "M3") (M4Layer string "M4") (M5Layer string "M5")
       (Via3 string "VIA3") (Via4 string "VIA4") (Via5 string "VIA5"))
      let((cv frame m4rings m3rings)
        cv = pcCellView
        frame = DFT28_createM4Frame(cv Pw Ps Tr Ra M4Layer)
        m4rings = DFT28_createM4Rings(cv Pw Ps Tr Ra M4Layer)
        m3rings = DFT28_createM3Rings(cv Pw Ps Tr Ra M3Layer)
        DFT28_createPortBridge(cv Pw Ps Tr Ra M3Layer M4Layer M5Layer Via3 Via4 Via5)
        printf("DFT28: created %s/%s demo top; frame=%L m4rings=%d m3rings=%d\n"
               libName cellName frame length(m4rings) length(m3rings))
      )
    )
  )
)

procedure(DFT28_defineAllPcells(libName)
  let(()
    DFT28_defineM4FramePCell(libName "dft28_m4_frame")
    DFT28_defineM4RingsPCell(libName "dft28_m4_rings")
    DFT28_defineM3RingsPCell(libName "dft28_m3_rings")
    DFT28_definePortBridgePCell(libName "dft28_port_bridge")
    DFT28_defineDemoTopPCell(libName "dft28_demo_top")
    printf("DFT28: defined split PCells in library %s\n" libName)
  )
)
